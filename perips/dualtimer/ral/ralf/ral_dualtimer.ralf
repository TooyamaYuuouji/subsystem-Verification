register TIMER1LOAD {
    bytes 4;

    field LOAD {
        bits 32;
        reset 32'h0000_0000;
        access rw;
    }
}

register TIMER1VALUE {
    bytes 4;

    field VALUE {
        bits 32;
        reset 32'hFFFF_FFFF;
        access ro;
    }
}

register TIMER1CONTROL {
    bytes 4;
    left_to_right;

    field EN {
        bits 1;
        reset 1'b0;
        access rw;
    }
    field MODE {
        bits 1;
        reset 1'b0;
        access rw;
    }
    field INT_EN {
        bits 1;
        reset 1'b1;
        access rw;
    }
    field RESERVED {
        bits 1;
        reset 1'b0;
        access wo;
    }
    field PRE {
        bits 2;
        reset 2'b00;
        access rw;
    }
    field SIZE {
        bits 1;
        reset 1'b0;
        access rw;
    }
    field ONESHOT {
        bits 1;
        reset 1'b0;
        access rw;
    }
}

register TIMER1INTCLR {
    bytes 4;

    field INT {
        bits 1;
        access wo;
    }
}

register TIMER1RIS {
    bytes 4;

    field RIS {
        bits 1;
        reset 1'h0;
        access ro;
    }
}

register TIMER1MIS {
    bytes 4;

    field RIS {
        bits 1;
        reset 1'h0;
        access ro;
    }
}

register TIMER1BGLOAD {
    bytes 4;

    field BGLOAD {
        bits 32;
        reset 32'h0000_0000;
        access rw;
    }
}

block ral_dualtimer {
    bytes 28;
    register TIMER1LOAD @'h00;
    register TIMER1VALUE @'h04;
    register TIMER1CONTROL @'h08;
    register TIMER1INTCLR @'h0C;
    register TIMER1RIS @'h10;
    register TIMER1MIS @'h14;
    register TIMER1BGLOAD @'h18;
}
